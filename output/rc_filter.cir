* rc_filter

R1 vin mc 10k
C1 mc gnd 10F

* test source auto-generated for port vin
V_test vin gnd PULSE(0 5 0 1n 1n 500u 1m)

.tran 1us 10ms
.end
